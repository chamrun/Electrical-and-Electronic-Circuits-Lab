** Profile: "SCHEMATIC1-4"  [ C:\Things\uni\3rdTerm\Elec\Lab\ElectricalAndElectronicCircuitsLab\ElecLab7\Orcad\lab7-SCHEMATIC1-4.sim ]

** Creating circuit file "lab7-SCHEMATIC1-4.sim.cir"
** WARNING: THIS AUTOMATICALLY GENERATED FILE MAY BE OVERWRITTEN BY SUBSEQUENT SIMULATIONS

*Libraries:
* Local Libraries :
* From [PSPICE NETLIST] section of C:\Program Files\Orcad\PSpice\PSpice.ini file:
.lib "nom.lib"

*Analysis directives:
.TRAN  0 2m 0
.PROBE V(*) I(*) W(*) D(*) NOISE(*)
.INC ".\lab7-SCHEMATIC1.net"

.END
